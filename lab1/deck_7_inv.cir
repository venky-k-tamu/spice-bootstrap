* Lab 1
* Technology: PTM 22nm HP, BSIM4 (level=54), nominal VDD = 0.8V
.include "inv.sub"

.param nom_vdd=0.8
.param WN=44n WP=88n LNCH=22n LPCH=22n
.param k=0.5
.param X=10p

VDD vdd 0 DC {nom_vdd}
VSS vss 0 DC 0

X0 in0 out0 vdd vss INV K=k
X1 out0 out1 vdd vss INV K=k
X2 out1 out2 vdd vss INV K=k
X3 out2 out3 vdd vss INV K=k
X4 out3 out4 vdd vss INV K=k
X5 out4 out5 vdd vss INV K=k
X6 out5 out6 vdd vss INV K=k

V1 in0 vss dc 0.8 PULSE (0.8 0 1n X X 1n 2n)

.control
tran 0.01p 3n
wrdata tran_data.txt in0 out2 out3
.endc

.end
